*
*
*
*                       LINUX           Fri Feb 27 11:46:45 2026
*
*
*
*  PROGRAM  advgen
*
*  Name           : advgen - Quantus - (64-bit)
*  Version        : 21.1.1-s329
*  Build Date     : Fri Aug 27 17:50:08 PDT 2021
*
*  HSPICE LIBRARY
*
*
*

*
.SUBCKT ADDFX1_lvt VDD VSS A B CI CO S
*
*
*  caps2d version: 10
*
*
*       TRANSISTOR CARDS
*
*
mn6	n4	B	VSS	VSS	g45n1lvt	L=4.5e-08
+ W=1.45e-07
+ AD=5.17e-14	AS=5.17e-14	PD=8.35e-07	PS=8.35e-07
+ scc=0.000213352 scb=0.00838479 sca=8.20642 sb=1.23e-06 sa=1.26292e-06
mn5	n4	A	VSS	VSS	g45n1lvt	L=4.5e-08
+ W=1.45e-07
+ AD=2.32e-14	AS=2.32e-14	PD=8.35e-07	PS=8.35e-07
+ scc=0.000213353 scb=0.00840365 sca=8.42746 sb=9.65e-07 sa=1.52795e-06
mn8	Sb	COb	n4	VSS	g45n1lvt	L=4.5e-08
+ W=1.45e-07
+ AD=2.32e-14	AS=2.32e-14	PD=6.1e-07	PS=6.1e-07
+ scc=0.000213372 scb=0.00851351 sca=8.82406 sb=7.6e-07 sa=1.73297e-06
mn11	Sb	CI	n7	VSS	g45n1lvt	L=4.5e-08
+ W=1.45e-07
+ AD=8.7e-15	AS=8.7e-15	PD=5.1e-07	PS=5.1e-07
+ scc=0.000214261 scb=0.00916122 sca=9.68811 sb=5.55e-07 sa=1.93799e-06
mn10	n7	B	n6	VSS	g45n1lvt	L=4.5e-08
+ W=1.45e-07
+ AD=8.7e-15	AS=8.7e-15	PD=4.1e-07	PS=4.1e-07
+ scc=0.00021962 scb=0.0102615 sca=10.5493 sb=4.5e-07 sa=2.04299e-06
mn9	n6	A	VSS	VSS	g45n1lvt	L=4.5e-08
+ W=1.45e-07
+ AD=3.47e-14	AS=3.47e-14	PD=6.25e-07	PS=6.25e-07
+ scc=0.000255095 scb=0.0127637 sca=12.0677 sb=3.45e-07 sa=2.148e-06
mn13	S	Sb	VSS	VSS	g45n1lvt	L=4.5e-08
+ W=2.6e-07
+ AD=3.64e-14	AS=3.64e-14	PD=8.2e-07	PS=8.2e-07
+ scc=0.00153404 scb=0.0250679 sca=20.7396 sb=1.4e-07 sa=2.37548e-07
mn7	n4	CI	VSS	VSS	g45n1lvt	L=4.5e-08
+ W=1.45e-07
+ AD=2.32e-14	AS=2.32e-14	PD=7.75e-07	PS=7.75e-07
+ scc=0.000213352 scb=0.00838345 sca=8.16145 sb=1.435e-06 sa=1.05789e-06
mn12	CO	COb	VSS	VSS	g45n1lvt	L=4.5e-08
+ W=2.6e-07
+ AD=3.22e-14	AS=3.22e-14	PD=8e-07	PS=8e-07
+ scc=0.00141457 scb=0.0208354 sca=18.2547 sb=1.22342e-07 sa=1.4e-07
mn2	n2	A	VSS	VSS	g45n1lvt	L=4.5e-08
+ W=1.45e-07
+ AD=3.31e-14	AS=3.31e-14	PD=7.55e-07	PS=7.55e-07
+ scc=0.000215255 scb=0.00947528 sca=9.96538 sb=2.36e-06 sa=1.31339e-07
mn3	n2	B	VSS	VSS	g45n1lvt	L=4.5e-08
+ W=1.45e-07
+ AD=2.32e-14	AS=2.32e-14	PD=7.75e-07	PS=7.75e-07
+ scc=0.000213394 scb=0.00856889 sca=8.9421 sb=2.155e-06 sa=3.37421e-07
mn4	COb	CI	n2	VSS	g45n1lvt	L=4.5e-08
+ W=1.45e-07
+ AD=2.32e-14	AS=2.32e-14	PD=6.1e-07	PS=6.1e-07
+ scc=0.000213353 scb=0.00841271 sca=8.48407 sb=1.95e-06 sa=5.4268e-07
mn1	COb	B	n0	VSS	g45n1lvt	L=4.5e-08
+ W=1.45e-07
+ AD=8.7e-15	AS=8.7e-15	PD=5.1e-07	PS=5.1e-07
+ scc=0.000213352 scb=0.00838753 sca=8.26388 sb=1.745e-06 sa=7.47797e-07
mn0	n0	A	VSS	VSS	g45n1lvt	L=4.5e-08
+ W=1.45e-07
+ AD=3.31e-14	AS=3.31e-14	PD=6.75e-07	PS=6.75e-07
+ scc=0.000213352 scb=0.0083847 sca=8.20421 sb=1.64e-06 sa=8.52835e-07
mp6	n5	B	VDD	VDD	g45p1lvt	L=4.5e-08
+ W=2.15e-07
+ AD=7.4575e-14	AS=7.4575e-14	PD=1.155e-06	PS=1.155e-06
+ scc=0.000425187 scb=0.0116184 sca=11.6635 sb=1.23e-06 sa=1.25522e-06
mp5	n5	A	VDD	VDD	g45p1lvt	L=4.5e-08
+ W=2.15e-07
+ AD=3.44e-14	AS=3.44e-14	PD=1.155e-06	PS=1.155e-06
+ scc=0.000425187 scb=0.0116316 sca=11.8412 sb=1e-06 sa=1.48524e-06
mp8	Sb	COb	n5	VDD	g45p1lvt	L=4.5e-08
+ W=2.15e-07
+ AD=3.44e-14	AS=3.44e-14	PD=7.5e-07	PS=7.5e-07
+ scc=0.000425197 scb=0.0117122 sca=12.1913 sb=7.95e-07 sa=1.69025e-06
mp11	Sb	CI	n9	VDD	g45p1lvt	L=4.5e-08
+ W=2.15e-07
+ AD=1.29e-14	AS=1.29e-14	PD=6.5e-07	PS=6.5e-07
+ scc=0.000425662 scb=0.0121934 sca=12.9409 sb=5.9e-07 sa=1.89526e-06
mp10	n9	B	n8	VDD	g45p1lvt	L=4.5e-08
+ W=2.15e-07
+ AD=1.29e-14	AS=1.29e-14	PD=5.5e-07	PS=5.5e-07
+ scc=0.000428491 scb=0.0130215 sca=13.6683 sb=4.85e-07 sa=2.00027e-06
mp9	n8	A	VDD	VDD	g45p1lvt	L=4.5e-08
+ W=2.15e-07
+ AD=6.055e-14	AS=6.055e-14	PD=8.6e-07	PS=8.6e-07
+ scc=0.000447479 scb=0.0149355 sca=14.9108 sb=3.8e-07 sa=2.10527e-06
mp13	S	Sb	VDD	VDD	g45p1lvt	L=4.5e-08
+ W=3.9e-07
+ AD=5.46e-14	AS=5.46e-14	PD=1.115e-06	PS=1.115e-06
+ scc=0.00196241 scb=0.0306644 sca=25.9341 sb=1.4e-07 sa=2.43794e-07
mp7	n5	CI	VDD	VDD	g45p1lvt	L=4.5e-08
+ W=2.15e-07
+ AD=3.44e-14	AS=3.44e-14	PD=1.15e-06	PS=1.15e-06
+ scc=0.000425187 scb=0.011617 sca=11.6186 sb=1.435e-06 sa=1.05019e-06
mp12	CO	COb	VDD	VDD	g45p1lvt	L=4.5e-08
+ W=3.9e-07
+ AD=5.615e-14	AS=5.615e-14	PD=1.195e-06	PS=1.195e-06
+ scc=0.00161065 scb=0.028294 sca=24.0579 sb=1.10493e-07 sa=1.4e-07
mp2	n3	A	VDD	VDD	g45p1lvt	L=4.5e-08
+ W=2.15e-07
+ AD=6.635e-14	AS=6.635e-14	PD=1.15e-06	PS=1.15e-06
+ scc=0.00042677 scb=0.0126204 sca=13.3482 sb=2.35e-06 sa=1.34056e-07
mp3	n3	B	VDD	VDD	g45p1lvt	L=4.5e-08
+ W=2.15e-07
+ AD=3.44e-14	AS=3.44e-14	PD=1.17e-06	PS=1.17e-06
+ scc=0.000425229 scb=0.0118025 sca=12.3992 sb=2.155e-06 sa=3.29838e-07
mp4	COb	CI	n3	VDD	g45p1lvt	L=4.5e-08
+ W=2.15e-07
+ AD=3.44e-14	AS=3.44e-14	PD=7.5e-07	PS=7.5e-07
+ scc=0.000425188 scb=0.0116463 sca=11.9412 sb=1.95e-06 sa=5.35037e-07
mp1	COb	B	n1	VDD	g45p1lvt	L=4.5e-08
+ W=2.15e-07
+ AD=1.29e-14	AS=1.29e-14	PD=6.5e-07	PS=6.5e-07
+ scc=0.000425187 scb=0.0116211 sca=11.721 sb=1.745e-06 sa=7.40124e-07
mp0	n1	A	VDD	VDD	g45p1lvt	L=4.5e-08
+ W=2.15e-07
+ AD=6.62e-14	AS=6.62e-14	PD=1.05e-06	PS=1.05e-06
+ scc=0.000425187 scb=0.0116183 sca=11.6613 sb=1.64e-06 sa=8.45152e-07
*
*
*       CAPACITOR CARDS
*
*
C1	A	VDD	1.19724e-16
C2	B	VDD	1.07445e-16
C3	CI	VDD	7.83989e-17
C4	CO	VDD	6.57479e-17
C5	S	VDD	8.07205e-17
C6	A	B	6.31472e-16
C7	n5	VDD	2.54735e-17
C8	A	CI	3.00826e-16
C9	Sb	VDD	8.92294e-17
C10	COb	n3	8.82324e-17
C11	n3	VDD	2.39654e-17
C12	COb	VDD	1.36323e-16
C13	B	CI	3.298e-16
C14	n2	COb	9.0863e-17
C15	Sb	A	1.63195e-16
C16	COb	A	1.66057e-16
C17	Sb	B	5.92629e-17
C18	Sb	CI	4.82962e-17
C19	COb	B	2.22645e-16
C20	n4	CI	8.37098e-17
C21	COb	CI	1.47215e-16
C22	Sb	S	9.82304e-17
C23	CO	COb	6.46608e-17
C24	COb	n5	9.25665e-17
C25	COb	Sb	5.45079e-17
C26	VDD	VSS	1.34421e-16
C27	A	VSS	6.10757e-17
C28	B	VSS	4.90253e-17
C29	CI	VSS	4.1514e-17
C30	CO	VSS	4.31019e-17
C31	S	VSS	2.3345e-17
C32	n6	VSS	1.19784e-18
C33	n7	VSS	7.05097e-19
C34	n0	VSS	7.0153e-19
C35	n8	VSS	1.0402e-18
C36	n9	VSS	1.0402e-18
C37	n1	VSS	1.55299e-18
C38	n5	VSS	1.80427e-17
C39	Sb	VSS	7.08274e-17
C40	n4	VSS	8.23796e-17
C41	n3	VSS	1.4975e-17
C42	n2	VSS	9.87614e-17
C43	COb	VSS	8.05862e-17
*
*
.ENDS ADDFX1_lvt
*
